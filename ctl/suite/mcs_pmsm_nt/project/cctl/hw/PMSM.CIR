PMSM (TINA Netlist Editor format)
**************************************
**  This file was created by TINA   **
**         www.tina.com             **
**      (c) DesignSoft, Inc.        **
**     www.designsoftware.com       **
**************************************
.LIB "<TINADIR>\EXAMPLES\SPICE\TSPICE.LIB"
.LIB "<TINADIR>\SPICELIB\Operational Amplifiers.LIB"
.TEMP 27
.AC DEC 20 10 1MEG
.TRAN 2N 1U
.DC LIN VPWM3 0 1 10M

.PROBE I(VAM3) I(VAM2) I(VAM1)

IPMSM1_C    1 2 10M
IPMSM1_B    3 2 10M
IPMSM1_A    4 2 10M
VAM3        5 4 ; Current Arrow
VAM2        6 3 ; Current Arrow
VAM1        7 1 ; Current Arrow
VPWM3       8 6 DC 0 AC 1 0
+ PULSE ( 0 1 0  0  0  1e19 1e20 )
VPWM4       10 0 DC 0 AC 1 0
+ PULSE ( 0 1 0  0  0  1e19 1e20 )
VPWM1       11 7 DC 0 AC 1 0
+ PULSE ( 0 1 0  0  0  1e19 1e20 )
VPWM2       12 0 DC 0 AC 1 0
+ PULSE ( 0 1 0  0  0  1e19 1e20 )
VPWM5       13 5 DC 0 AC 1 0
+ PULSE ( 0 1 0  0  0  1e19 1e20 )
VPWM6       15 0 DC 0 AC 1 0
+ PULSE ( 0 1 0  0  0  1e19 1e20 )
VS1         14 0 5
R11         2 0 1MEG
MT6         9 8 6 6  ME_2N6755_N_1 NRD=0 NRS=0
MT5         6 10 0 0  ME_2N6755_N_1 NRD=0 NRS=0
MT4         9 11 7 7  ME_2N6755_N_1 NRD=0 NRS=0
MT3         7 12 0 0  ME_2N6755_N_1 NRD=0 NRS=0
MT2         9 13 5 5  ME_2N6755_N_1 NRD=0 NRS=0
R3          14 9 50M
C2          9 0 100U
MT1         5 15 0 0  ME_2N6755_N_1 NRD=0 NRS=0
C1          9 0 100U

.MODEL ME_2N6755_N_1 NMOS( LEVEL=3 VTO=3.128 KP=21.14U PHI=600M GAMMA=0 TOX=100N
+      UO=600 VMAX=0 DELTA=0 THETA=0 ETA=0
+      L=2U W=1.1 RD=64.68M RS=120.7M RG=5.839
+      RB=0 RDS=600K IS=44.14F N=1 PB=800M
+      CBD=1.261N CBS=0 MJ=500M TT=370N CGSO=725.6P
+      CGDO=310.6P CGBO=0 KF=0 AF=1 )

.END
