*// Transient Simulation //*
********************************************************************************
* Wed Aug 19 2026 13:46:25 GMT+0800 (中国标准时间)
*
* Texas Instruments Incorporated
* ASC-INT-LOGIC
* 12500 TI Blvd
* Dallas, TX 75243
*
* Automated model revision history:
* Rev 1.0: [[RELEASE DATE]]
* - Initial version
*
********************************************************************************
*[Disclaimer]
* This model is designed as an aid for customers of Texas Instruments.
* TI and its licensors and suppliers make no warranties, either expressed
* or implied, with respect to this  model, including the warranties of
* merchantability or fitness for a particular purpose. The model is
* provided solely on an "as is" basis. The entire risk as to its quality
* and performance is with the customer.
*
*[Copyright]
*(C) Copyright 2026 Texas Instruments Incorporated. All rights reserved.
********************************************************************************
*// This file generated by InterConnect Studio for simulation with ngspice //*
.include "C:\ti\interconnectstudio_1.8.0\product\source\ti\tpld\.meta\templates\subcircuits\prim_cells_ngspice.mod"
.include "C:\ti\interconnectstudio_1.8.0\product\source\ti\tpld\.meta\templates\subcircuits\dff_ngspice.mod"
.include "C:\ti\interconnectstudio_1.8.0\product\source\ti\tpld\.meta\templates\subcircuits\dff_sr8.mod"
.include "C:\ti\interconnectstudio_1.8.0\product\source\ti\tpld\.meta\templates\subcircuits\dff2_tpld1202.mod"
.include "C:\ti\interconnectstudio_1.8.0\product\source\ti\tpld\.meta\templates\subcircuits\cntr.mod"
.include "C:\ti\interconnectstudio_1.8.0\product\source\ti\tpld\.meta\templates\subcircuits\cntr_dly_1202.mod"
.include "C:\ti\interconnectstudio_1.8.0\product\source\ti\tpld\.meta\templates\subcircuits\pwm.mod"
.include "C:\ti\interconnectstudio_1.8.0\product\source\ti\tpld\.meta\templates\subcircuits\pdly.mod"
.include "C:\ti\interconnectstudio_1.8.0\product\source\ti\tpld\.meta\templates\subcircuits\wdt.mod"
.include "C:\ti\interconnectstudio_1.8.0\product\source\ti\tpld\.meta\templates\subcircuits\asm.mod"
.include "C:\ti\interconnectstudio_1.8.0\product\source\ti\tpld\.meta\templates\subcircuits\pgen.mod"
.include "C:\ti\interconnectstudio_1.8.0\product\source\ti\tpld\.meta\templates\subcircuits\mcacmp.mod"
.func if(a,b,c) 'ternary_fcn( a , b , c )'
.options trtol=1

* system

* CAPACITOR HANDLING

* RESISTOR HANDLING

* INDUCTOR HANDLING

* DIODE HANDLING

* SCHOTTKY DIODE HANDLING

* ZENER DIODE HANDLING

* NPN BJT HANDLING

* PNP BJT HANDLING

* NMOS HANDLING

* PMOS HANDLING

* VOLTAGE SOURCE HANDLING

* CURRENT SOURCE HANDLING

* VCC HANDLING

* TPLD HANDLING
X_dynamic1 VCC0_OUT 0 pin0_IN_EXT_dynamic1 pin1_IN_EXT_dynamic1 pin2_IN_EXT_dynamic1 pin3_IN_EXT_dynamic1 pin4_IN_EXT_dynamic1 pin5_IN_EXT_dynamic1 pin7_OUT_EXT_dynamic1 pin8_IN_EXT_dynamic1 pin9_OUT_EXT_dynamic1 SCL_IN_EXT_dynamic1 SDA_IN_EXT_dynamic1 pin6_OUT_EXT_dynamic1 pin10_OUT_EXT_dynamic1 pin11_OUT_EXT_dynamic1 TPLD2001_dynamic1

* $dynamic1
.SUBCKT TPLD2001_dynamic1 VDD GND pin0_IN_dynamic1 pin1_IN_dynamic1 pin2_IN_dynamic1 pin3_IN_dynamic1 pin4_IN_dynamic1 pin5_IN_dynamic1 pin7_OUT_dynamic1 pin8_IN_dynamic1 pin9_OUT_dynamic1 SCL_IN_dynamic1 SDA_IN_dynamic1 pin6_OUT_dynamic1 pin10_OUT_dynamic1 pin11_OUT_dynamic1
*// This is the auto-power-on signal for the oscillator
*// by default it is off (A_OUT_ON = 0V)
*// Any module can pull the node HIGH to activate
RAUTO_ON A_AUTO_ON A_ZERO 1k
AAUTO_ON [A_AUTO_ON] [D_AUTO_ON] adc_ideal

*// Used for preventing floating nodes
R101 error1 GND 1k
R102 error2 GND 1k
R103 error3 GND 1k
R104 error4 GND 1k

EROH1X ROH1X GND TABLE {V(VDD)} =
+ (1.8,61)
+ (3.3,50)
+ (5,37)
EROL1X ROL1X GND TABLE {V(VDD)} =
+ (1.8,18)
+ (3.3,14)
+ (5,9)
EROH2X ROH2X GND TABLE {V(VDD)} =
+ (1.8,31)
+ (3.3,25)
+ (5,18)
EROL2X ROL2X GND TABLE {V(VDD)} =
+ (1.8,7)
+ (3.3,6)
+ (5,4)

*// ACMP //*

*// AMUX //*

*// MCACMP //*

*// BANDGAP //*

*// CNT //*

*// PWM //*

*// PGEN //*

*// DFF //*
X_dff2 D_STARTUP D__lut7_OUT D__lut1_OUT D__lut8_OUT D_ZERO D_ZERO D_ZERO D_ZERO D_ZERO D_ZERO D_ONE D__dff2_OUT dff2_tpld1202
X_dff0 D_STARTUP D__lut7_OUT D__lut3_OUT D__lut9_OUT D_ZERO D_ZERO D_ZERO D_ZERO D_ZERO D_ZERO D_ONE D__dff0_OUT dff2_tpld1202
X_dff1 D_STARTUP D__lut7_OUT D__lut6_OUT D__25MHz0_OUT0 D_ZERO D_ZERO D_ZERO D_ZERO D_ZERO D_ZERO D_ZERO D__dff1_OUT dff2_tpld1202
X_dff3 D_STARTUP D__lut7_OUT D__lut10_OUT D__25MHz0_OUT0 D_ZERO D_ZERO D_ZERO D_ZERO D_ZERO D_ZERO D_ZERO D__dff3_OUT dff2_tpld1202

*// SR //*

*// Edge Detect //*

*// One-Shot //*

*// Frequency Detect //*

*// DLY //*

*// ASM //*

*// WDT //*

*// FILTER //*

*// GND //*
VA_ZERO A_ZERO GND 0
ABRIDGE_DZERO [A_ZERO] [D_ZERO] adc_ideal

*// LUT //*
ABUF_lut0_A D__pin1_OUT D__lut0_A buf_ideal
ABUF_lut0_B D__pin2_OUT D__lut0_B buf_ideal
ALUT2__lut0 [D__lut0_A D__lut0_B] D__lut0_OUT LUT2__lut0
.model LUT2__lut0 d_lut(table_values="00010001" input_load=1e-15 rise_delay=27.5n fall_delay=27.5n)
ABUF_lut1_A D__lut0_OUT D__lut1_A buf_ideal
ABUF_lut1_B D__dff2_OUT D__lut1_B buf_ideal
ALUT2__lut1 [D__lut1_A D__lut1_B] D__lut1_OUT LUT2__lut1
.model LUT2__lut1 d_lut(table_values="01110111" input_load=1e-15 rise_delay=27.5n fall_delay=27.5n)
ABUF_lut2_A D__pin4_OUT D__lut2_A buf_ideal
ABUF_lut2_B D__pin5_OUT D__lut2_B buf_ideal
ALUT2__lut2 [D__lut2_A D__lut2_B] D__lut2_OUT LUT2__lut2
.model LUT2__lut2 d_lut(table_values="01110111" input_load=1e-15 rise_delay=27.5n fall_delay=27.5n)
ABUF_lut3_A D__lut2_OUT D__lut3_A buf_ideal
ABUF_lut3_B D__dff0_OUT D__lut3_B buf_ideal
ALUT2__lut3 [D__lut3_A D__lut3_B] D__lut3_OUT LUT2__lut3
.model LUT2__lut3 d_lut(table_values="01110111" input_load=1e-15 rise_delay=27.5n fall_delay=27.5n)
ABUF_lut4_A D__dff2_OUT D__lut4_A buf_ideal
ABUF_lut4_B D__dff0_OUT D__lut4_B buf_ideal
ALUT2__lut4 [D__lut4_A D__lut4_B] D__lut4_OUT LUT2__lut4
.model LUT2__lut4 d_lut(table_values="01110111" input_load=1e-15 rise_delay=27.5n fall_delay=27.5n)
ABUF_lut5_A D__dff2_OUT D__lut5_A buf_ideal
ABUF_lut5_B D__dff0_OUT D__lut5_B buf_ideal
ABUF_lut5_C D__dff3_OUT D__lut5_C buf_ideal
ALUT3__lut5 [D__lut5_A D__lut5_B D__lut5_C] D__lut5_OUT LUT3__lut5
.model LUT3__lut5 d_lut(table_values="01111111" input_load=1e-15 rise_delay=27.5n fall_delay=27.5n)
ABUF_lut6_A D__pflt0_OUT D__lut6_A buf_ideal
ABUF_lut6_B D__dff1_OUT D__lut6_B buf_ideal
ALUT2__lut6 [D__lut6_A D__lut6_B] D__lut6_OUT LUT2__lut6
.model LUT2__lut6 d_lut(table_values="01110111" input_load=1e-15 rise_delay=27.5n fall_delay=27.5n)
ABUF_lut8_A D__lut0_OUT D__lut8_A buf_ideal
A_lut8_LUTINV D__lut8_A D__lut8_OUT INV__lut8
.model INV__lut8 d_inverter(rise_delay=27.5n fall_delay=27.5n input_load=1e-15)
ABUF_lut9_A D__lut2_OUT D__lut9_A buf_ideal
A_lut9_LUTINV D__lut9_A D__lut9_OUT INV__lut9
.model INV__lut9 d_inverter(rise_delay=27.5n fall_delay=27.5n input_load=1e-15)
ABUF_lut10_A D__pin0_OUT D__lut10_A buf_ideal
ABUF_lut10_B D__dff3_OUT D__lut10_B buf_ideal
ALUT2__lut10 [D__lut10_A D__lut10_B] D__lut10_OUT LUT2__lut10
.model LUT2__lut10 d_lut(table_values="0111" input_load=1e-15 rise_delay=27.5n fall_delay=27.5n)
ABUF_lut7_A D__lut0_OUT D__lut7_A buf_ideal
ABUF_lut7_B D__lut2_OUT D__lut7_B buf_ideal
ABUF_lut7_C D__pin0_OUT D__lut7_C buf_ideal
ABUF_lut7_D D__pin3_OUT D__lut7_D buf_ideal
ALUT4__lut7 [D__lut7_A D__lut7_B D__lut7_C D__lut7_D] D__lut7_OUT LUT4__lut7
.model LUT4__lut7 d_lut(table_values="0111111111111111" input_load=1e-15 rise_delay=27.5n fall_delay=27.5n)
ABUF_lut11_A D__lut5_OUT D__lut11_A buf_ideal
ABUF_lut11_B D__dff1_OUT D__lut11_B buf_ideal
ABUF_lut11_C D__pflt0_OUT D__lut11_C buf_ideal
ALUT3__lut11 [D__lut11_A D__lut11_B D__lut11_C] D__lut11_OUT LUT3__lut11
.model LUT3__lut11 d_lut(table_values="01111111" input_load=1e-15 rise_delay=27.5n fall_delay=27.5n)
ABUF_lut12_A D__lut11_OUT D__lut12_A buf_ideal
ABUF_lut12_B D__pin1_OUT D__lut12_B buf_ideal
ALUT2__lut12 [D__lut12_A D__lut12_B] D__lut12_OUT LUT2__lut12
.model LUT2__lut12 d_lut(table_values="0010" input_load=1e-15 rise_delay=27.5n fall_delay=27.5n)
ABUF_lut13_A D__pin2_OUT D__lut13_A buf_ideal
ABUF_lut13_B D__lut11_OUT D__lut13_B buf_ideal
ALUT2__lut13 [D__lut13_A D__lut13_B] D__lut13_OUT LUT2__lut13
.model LUT2__lut13 d_lut(table_values="0100" input_load=1e-15 rise_delay=27.5n fall_delay=27.5n)

*// OSC //*

*// OSC0 //*

*// OSC1 //*
.model osc_dly_25MHz0 d_buffer(rise_delay=8e-9 fall_delay=8e-9 input_load=1e-15)
.model osc_su_dly_25MHz0 d_buffer(rise_delay=1e-7 fall_delay=1e-9 input_load=1e-15)
A_25MHz0_finishbuf D_ONE D__25MHz0_FINISH buf_del_1ns
A_25MHz0_or1 [D_AUTO_ON D_ZERO] D__25MHz0_PUPOR or_del_1ns
A_25MHz0_andpor [D_STARTUP D__25MHz0_PUPOR] D__25MHz0_PUPORAND and_del_1ns
A_25MHz0_su_dly D__25MHz0_PUPORAND D__25MHz0_PUP_DEL osc_su_dly_25MHz0
A_25MHz0_and2 [D__25MHz0_FINISH D__25MHz0_DFF_OUT] D__25MHz0_FINISHSIG and_del_1ns
A_25MHz0_or2 [D__25MHz0_PUP_DEL D__25MHz0_FINISHSIG] D__25MHz0_PUPOR2 or_del_1ns
A_25MHz0_and1 [D__25MHz0_FB D__25MHz0_PUPOR2] D__25MHz0_OSC_INT and_del_1ns
A_25MHz0_osc_dly D__25MHz0_OSC_INT D__25MHz0_DELAYED osc_dly_25MHz0
A_25MHz0_osc_inv D__25MHz0_DELAYED D__25MHz0_FB inv_del_1ns
A_25MHz0_osc_dff D__25MHz0_DFF_QBAR D__25MHz0_OSC_INT D_ZERO D_ZERO D__25MHz0_DFF_OUT D__25MHz0_DFF_QBAR dff_ideal
A_25MHz0_osc_link D__25MHz0_DFF_OUT D__25MHz0_OSC buf_ideal
A_25MHz0_OUT0 D__25MHz0_OSC D__25MHz0_OUT0 buf_ideal
A_25MHz0_OSC2_DIV1 D__25MHz0_OSC D__25MHz0_OSC2_DIV1 buf_ideal
A_25MHz0_OSC2_DIV4 D__25MHz0_OSC D__25MHz0_OSC2_DIV4_MULT2 div_OSC2_DIV4_25MHz0
.model div_OSC2_DIV4_25MHz0 d_fdiv(div_factor=2 high_cycles=1 i_count=0 rise_delay=1e-12 fall_delay=1e-12)
A_25MHz0_DFF_OSC2_DIV4 D__25MHz0_OSC2_DIV4_Q_BAR D__25MHz0_OSC2_DIV4_MULT2 D_ZERO D_ZERO D__25MHz0_OSC2_DIV4 D__25MHz0_OSC2_DIV4_Q_BAR dff_ideal
A_25MHz0_OSC1_DIV1 D__25MHz0_OSC D__25MHz0_OSC1_DIV1 buf_ideal
A_25MHz0_OSC1_DIV2 D__25MHz0_OSC1_DIV2_Q_BAR D__25MHz0_OSC D_ZERO D_ZERO D__25MHz0_OSC1_DIV2 D__25MHz0_OSC1_DIV2_Q_BAR dff_ideal
A_25MHz0_OSC1_DIV4 D__25MHz0_OSC D__25MHz0_OSC1_DIV4_MULT2 div_OSC1_DIV4_25MHz0
.model div_OSC1_DIV4_25MHz0 d_fdiv(div_factor=2 high_cycles=1 i_count=0 rise_delay=1e-12 fall_delay=1e-12)
A_25MHz0_DFF_OSC1_DIV4 D__25MHz0_OSC1_DIV4_Q_BAR D__25MHz0_OSC1_DIV4_MULT2 D_ZERO D_ZERO D__25MHz0_OSC1_DIV4 D__25MHz0_OSC1_DIV4_Q_BAR dff_ideal
A_25MHz0_OSC1_DIV8 D__25MHz0_OSC D__25MHz0_OSC1_DIV8_MULT2 div_OSC1_DIV8_25MHz0
.model div_OSC1_DIV8_25MHz0 d_fdiv(div_factor=4 high_cycles=1 i_count=0 rise_delay=1e-12 fall_delay=1e-12)
A_25MHz0_DFF_OSC1_DIV8 D__25MHz0_OSC1_DIV8_Q_BAR D__25MHz0_OSC1_DIV8_MULT2 D_ZERO D_ZERO D__25MHz0_OSC1_DIV8 D__25MHz0_OSC1_DIV8_Q_BAR dff_ideal
A_25MHz0_OSC1_DIV20 D__25MHz0_OSC D__25MHz0_OSC1_DIV20_MULT2 div_OSC1_DIV20_25MHz0
.model div_OSC1_DIV20_25MHz0 d_fdiv(div_factor=10 high_cycles=1 i_count=0 rise_delay=1e-12 fall_delay=1e-12)
A_25MHz0_DFF_OSC1_DIV20 D__25MHz0_OSC1_DIV20_Q_BAR D__25MHz0_OSC1_DIV20_MULT2 D_ZERO D_ZERO D__25MHz0_OSC1_DIV20 D__25MHz0_OSC1_DIV20_Q_BAR dff_ideal
A_25MHz0_OSC1_DIV40 D__25MHz0_OSC D__25MHz0_OSC1_DIV40_MULT2 div_OSC1_DIV40_25MHz0
.model div_OSC1_DIV40_25MHz0 d_fdiv(div_factor=20 high_cycles=1 i_count=0 rise_delay=1e-12 fall_delay=1e-12)
A_25MHz0_DFF_OSC1_DIV40 D__25MHz0_OSC1_DIV40_Q_BAR D__25MHz0_OSC1_DIV40_MULT2 D_ZERO D_ZERO D__25MHz0_OSC1_DIV40 D__25MHz0_OSC1_DIV40_Q_BAR dff_ideal
A_25MHz0_OSC1_DIV64 D__25MHz0_OSC D__25MHz0_OSC1_DIV64_MULT2 div_OSC1_DIV64_25MHz0
.model div_OSC1_DIV64_25MHz0 d_fdiv(div_factor=32 high_cycles=1 i_count=0 rise_delay=1e-12 fall_delay=1e-12)
A_25MHz0_DFF_OSC1_DIV64 D__25MHz0_OSC1_DIV64_Q_BAR D__25MHz0_OSC1_DIV64_MULT2 D_ZERO D_ZERO D__25MHz0_OSC1_DIV64 D__25MHz0_OSC1_DIV64_Q_BAR dff_ideal
A_25MHz0_OSC1_DIV512 D__25MHz0_OSC D__25MHz0_OSC1_DIV512_MULT2 div_OSC1_DIV512_25MHz0
.model div_OSC1_DIV512_25MHz0 d_fdiv(div_factor=256 high_cycles=1 i_count=0 rise_delay=1e-12 fall_delay=1e-12)
A_25MHz0_DFF_OSC1_DIV512 D__25MHz0_OSC1_DIV512_Q_BAR D__25MHz0_OSC1_DIV512_MULT2 D_ZERO D_ZERO D__25MHz0_OSC1_DIV512 D__25MHz0_OSC1_DIV512_Q_BAR dff_ideal
A_25MHz0_OSC0_DIV1 D__25MHz0_OSC D__25MHz0_OSC0_DIV1 buf_ideal
A_25MHz0_OSC0_DIV2 D__25MHz0_OSC0_DIV2_Q_BAR D__25MHz0_OSC D_ZERO D_ZERO D__25MHz0_OSC0_DIV2 D__25MHz0_OSC0_DIV2_Q_BAR dff_ideal
A_25MHz0_OSC0_DIV8 D__25MHz0_OSC D__25MHz0_OSC0_DIV8_MULT2 div_OSC0_DIV8_25MHz0
.model div_OSC0_DIV8_25MHz0 d_fdiv(div_factor=4 high_cycles=1 i_count=0 rise_delay=1e-12 fall_delay=1e-12)
A_25MHz0_DFF_OSC0_DIV8 D__25MHz0_OSC0_DIV8_Q_BAR D__25MHz0_OSC0_DIV8_MULT2 D_ZERO D_ZERO D__25MHz0_OSC0_DIV8 D__25MHz0_OSC0_DIV8_Q_BAR dff_ideal
A_25MHz0_OSC0_DIV64 D__25MHz0_OSC D__25MHz0_OSC0_DIV64_MULT2 div_OSC0_DIV64_25MHz0
.model div_OSC0_DIV64_25MHz0 d_fdiv(div_factor=32 high_cycles=1 i_count=0 rise_delay=1e-12 fall_delay=1e-12)
A_25MHz0_DFF_OSC0_DIV64 D__25MHz0_OSC0_DIV64_Q_BAR D__25MHz0_OSC0_DIV64_MULT2 D_ZERO D_ZERO D__25MHz0_OSC0_DIV64 D__25MHz0_OSC0_DIV64_Q_BAR dff_ideal
A_25MHz0_OSC0_DIV512 D__25MHz0_OSC D__25MHz0_OSC0_DIV512_MULT2 div_OSC0_DIV512_25MHz0
.model div_OSC0_DIV512_25MHz0 d_fdiv(div_factor=256 high_cycles=1 i_count=0 rise_delay=1e-12 fall_delay=1e-12)
A_25MHz0_DFF_OSC0_DIV512 D__25MHz0_OSC0_DIV512_Q_BAR D__25MHz0_OSC0_DIV512_MULT2 D_ZERO D_ZERO D__25MHz0_OSC0_DIV512 D__25MHz0_OSC0_DIV512_Q_BAR dff_ideal
A_25MHz0_OSC0_DIV4096 D__25MHz0_OSC D__25MHz0_OSC0_DIV4096_MULT2 div_OSC0_DIV4096_25MHz0
.model div_OSC0_DIV4096_25MHz0 d_fdiv(div_factor=2048 high_cycles=1 i_count=0 rise_delay=1e-12 fall_delay=1e-12)
A_25MHz0_DFF_OSC0_DIV4096 D__25MHz0_OSC0_DIV4096_Q_BAR D__25MHz0_OSC0_DIV4096_MULT2 D_ZERO D_ZERO D__25MHz0_OSC0_DIV4096 D__25MHz0_OSC0_DIV4096_Q_BAR dff_ideal
A_25MHz0_OSC0_DIV32768 D__25MHz0_OSC D__25MHz0_OSC0_DIV32768_MULT2 div_OSC0_DIV32768_25MHz0
.model div_OSC0_DIV32768_25MHz0 d_fdiv(div_factor=16384 high_cycles=1 i_count=0 rise_delay=1e-12 fall_delay=1e-12)
A_25MHz0_DFF_OSC0_DIV32768 D__25MHz0_OSC0_DIV32768_Q_BAR D__25MHz0_OSC0_DIV32768_MULT2 D_ZERO D_ZERO D__25MHz0_OSC0_DIV32768 D__25MHz0_OSC0_DIV32768_Q_BAR dff_ideal
A_25MHz0_OSC0_DIV262144 D__25MHz0_OSC D__25MHz0_OSC0_DIV262144_MULT2 div_OSC0_DIV262144_25MHz0
.model div_OSC0_DIV262144_25MHz0 d_fdiv(div_factor=131072 high_cycles=1 i_count=0 rise_delay=1e-12 fall_delay=1e-12)
A_25MHz0_DFF_OSC0_DIV262144 D__25MHz0_OSC0_DIV262144_Q_BAR D__25MHz0_OSC0_DIV262144_MULT2 D_ZERO D_ZERO D__25MHz0_OSC0_DIV262144 D__25MHz0_OSC0_DIV262144_Q_BAR dff_ideal

*// OSC2 //*

*// PDLY //*
A_DAC_0__pflt0 [D__pin8_OUT] [A_pflt0_0] dac_ideal
R0_pflt0        A_pflt0_0 A_pflt0_DEL0 250k
C0_pflt0        A_pflt0_DEL0 0 425f
AHYST_0__pflt0   A_pflt0_DEL0 A__pflt0_HYST0 hyst_pdly
A_ADC_0__pflt0 [A__pflt0_HYST0] [D_pflt0_DEL0] adc_ideal
A_BUF_0__pflt0 D_pflt0_DEL0 dly1_out_rise_i buf_ideal
X_pflt0 D__pin8_OUT D_pflt0_DEL0 D_pflt0_DEL0 dly1_out_rise_i D_ZERO D_ZERO D_ZERO D_ZERO D__pflt0_OUT pdly

*// PIN //*

CINA__pin0 pin0_IN_dynamic1 VDD 1.5e-12
CINB__pin0 pin0_IN_dynamic1 GND 1.5e-12
RINA__pin0 pin0_IN_dynamic1 VDD 100000000
RINB__pin0 pin0_IN_dynamic1 GND 100000000
DN__pin0 GND pin0_IN_dynamic1 clamp_diode_1 ; negative clamp
DP__pin0 pin0_IN_dynamic1 VDD clamp_diode_1 ; positive clamp

Enorm__pin0 A_norm__pin0 GND VALUE={V(pin0_IN_dynamic1,0)/V(VDD,0)}
ABRIDGE-IN__pin0 [A_norm__pin0] [D_norm_del__pin0] adc_norm
Xdel__pin0 D_norm_del__pin0 D__pin0_OUT DELAY_DIST_LUT

CINA__pin1 pin1_IN_dynamic1 VDD 1.5e-12
CINB__pin1 pin1_IN_dynamic1 GND 1.5e-12
RINA__pin1 pin1_IN_dynamic1 VDD 100000000
RINB__pin1 pin1_IN_dynamic1 GND 100000000
DN__pin1 GND pin1_IN_dynamic1 clamp_diode_1 ; negative clamp
DP__pin1 pin1_IN_dynamic1 VDD clamp_diode_1 ; positive clamp

Enorm__pin1 A_norm__pin1 GND VALUE={V(pin1_IN_dynamic1,0)/V(VDD,0)}
ABRIDGE-IN__pin1 [A_norm__pin1] [D_norm_del__pin1] adc_norm
Xdel__pin1 D_norm_del__pin1 D__pin1_OUT DELAY_DIST_LUT

CINA__pin2 pin2_IN_dynamic1 VDD 1.5e-12
CINB__pin2 pin2_IN_dynamic1 GND 1.5e-12
RINA__pin2 pin2_IN_dynamic1 VDD 100000000
RINB__pin2 pin2_IN_dynamic1 GND 100000000
DN__pin2 GND pin2_IN_dynamic1 clamp_diode_1 ; negative clamp
DP__pin2 pin2_IN_dynamic1 VDD clamp_diode_1 ; positive clamp

Enorm__pin2 A_norm__pin2 GND VALUE={V(pin2_IN_dynamic1,0)/V(VDD,0)}
ABRIDGE-IN__pin2 [A_norm__pin2] [D_norm_del__pin2] adc_norm
Xdel__pin2 D_norm_del__pin2 D__pin2_OUT DELAY_DIST_LUT

CINA__pin3 pin3_IN_dynamic1 VDD 1.5e-12
CINB__pin3 pin3_IN_dynamic1 GND 1.5e-12
RINA__pin3 pin3_IN_dynamic1 VDD 100000000
RINB__pin3 pin3_IN_dynamic1 GND 100000000
DN__pin3 GND pin3_IN_dynamic1 clamp_diode_1 ; negative clamp
DP__pin3 pin3_IN_dynamic1 VDD clamp_diode_1 ; positive clamp

Enorm__pin3 A_norm__pin3 GND VALUE={V(pin3_IN_dynamic1,0)/V(VDD,0)}
ABRIDGE-IN__pin3 [A_norm__pin3] [D_norm_del__pin3] adc_norm
Xdel__pin3 D_norm_del__pin3 D__pin3_OUT DELAY_DIST_LUT

CINA__pin4 pin4_IN_dynamic1 VDD 1.5e-12
CINB__pin4 pin4_IN_dynamic1 GND 1.5e-12
RINA__pin4 pin4_IN_dynamic1 VDD 100000000
RINB__pin4 pin4_IN_dynamic1 GND 100000000
DN__pin4 GND pin4_IN_dynamic1 clamp_diode_1 ; negative clamp
DP__pin4 pin4_IN_dynamic1 VDD clamp_diode_1 ; positive clamp

Enorm__pin4 A_norm__pin4 GND VALUE={V(pin4_IN_dynamic1,0)/V(VDD,0)}
ABRIDGE-IN__pin4 [A_norm__pin4] [D_norm_del__pin4] adc_norm
Xdel__pin4 D_norm_del__pin4 D__pin4_OUT DELAY_DIST_LUT

CINA__pin5 pin5_IN_dynamic1 VDD 1.5e-12
CINB__pin5 pin5_IN_dynamic1 GND 1.5e-12
RINA__pin5 pin5_IN_dynamic1 VDD 100000000
RINB__pin5 pin5_IN_dynamic1 GND 100000000
DN__pin5 GND pin5_IN_dynamic1 clamp_diode_1 ; negative clamp
DP__pin5 pin5_IN_dynamic1 VDD clamp_diode_1 ; positive clamp

Enorm__pin5 A_norm__pin5 GND VALUE={V(pin5_IN_dynamic1,0)/V(VDD,0)}
ABRIDGE-IN__pin5 [A_norm__pin5] [D_norm_del__pin5] adc_norm
Xdel__pin5 D_norm_del__pin5 D__pin5_OUT DELAY_DIST_LUT

* Leakage current at outputs:
R_pin7POSOUTLEAK pin7_OUT_dynamic1 VDD 5e+7
R_pin7NEGOUTLEAK pin7_OUT_dynamic1 GND 5e+7
COUTA__pin7 pin7_OUT_dynamic1 VDD 1.5e-12
COUTB__pin7 pin7_OUT_dynamic1 GND 1.5e-12
ROUTA__pin7 pin7_OUT_dynamic1 VDD 100000000
ROUTB__pin7 pin7_OUT_dynamic1 GND 100000000

R_pin7_OE A_ONE A__pin7_HIZ 1
ABRIDGE-OUT__pin7 [D__lut4_OUT] [A_I__pin7] dac_pin_out
EOUT__pin7 A_OUT_INT__pin7 GND VALUE = {V(A_I__pin7)*V(VDD,GND)}
GOUT__pin7 pin7_OUT_dynamic1 A_OUT_INT__pin7 VALUE = { V(A_STARTUP)*V(A__pin7_HIZ)*(
+ 1*V(A_I__pin7)*V(pin7_OUT_dynamic1,A_OUT_INT__pin7)/V(ROH1X)+
+ 1*(1-V(A_I__pin7))*V(pin7_OUT_dynamic1,A_OUT_INT__pin7)/V(ROL1X)
+ )}

CINA__pin8 pin8_IN_dynamic1 VDD 1.5e-12
CINB__pin8 pin8_IN_dynamic1 GND 1.5e-12
RINA__pin8 pin8_IN_dynamic1 VDD 100000000
RINB__pin8 pin8_IN_dynamic1 GND 100000000
DN__pin8 GND pin8_IN_dynamic1 clamp_diode_1 ; negative clamp
DP__pin8 pin8_IN_dynamic1 VDD clamp_diode_1 ; positive clamp

Enorm__pin8 A_norm__pin8 GND VALUE={V(pin8_IN_dynamic1,0)/V(VDD,0)}
ABRIDGE-IN__pin8 [A_norm__pin8] [D_norm_del__pin8] adc_norm
Xdel__pin8 D_norm_del__pin8 D__pin8_OUT DELAY_DIST_LUT

* Leakage current at outputs:
R_pin9POSOUTLEAK pin9_OUT_dynamic1 VDD 5e+7
R_pin9NEGOUTLEAK pin9_OUT_dynamic1 GND 5e+7
COUTA__pin9 pin9_OUT_dynamic1 VDD 1.5e-12
COUTB__pin9 pin9_OUT_dynamic1 GND 1.5e-12
ROUTA__pin9 pin9_OUT_dynamic1 VDD 100000000
ROUTB__pin9 pin9_OUT_dynamic1 GND 100000000

R_pin9_OE A_ONE A__pin9_HIZ 1
ABRIDGE-OUT__pin9 [D__lut5_OUT] [A_I__pin9] dac_pin_out
EOUT__pin9 A_OUT_INT__pin9 GND VALUE = {V(A_I__pin9)*V(VDD,GND)}
GOUT__pin9 pin9_OUT_dynamic1 A_OUT_INT__pin9 VALUE = { V(A_STARTUP)*V(A__pin9_HIZ)*(
+ 1*V(A_I__pin9)*V(pin9_OUT_dynamic1,A_OUT_INT__pin9)/V(ROH1X)+
+ 1*(1-V(A_I__pin9))*V(pin9_OUT_dynamic1,A_OUT_INT__pin9)/V(ROL1X)
+ )}

CINA__SCL SCL_IN_dynamic1 VDD 1.5e-12
CINB__SCL SCL_IN_dynamic1 GND 1.5e-12
RINA__SCL SCL_IN_dynamic1 VDD 100000000
RINB__SCL SCL_IN_dynamic1 GND 100000000
DN__SCL GND SCL_IN_dynamic1 clamp_diode_1 ; negative clamp
DP__SCL SCL_IN_dynamic1 VDD clamp_diode_1 ; positive clamp

Enorm__SCL A_norm__SCL GND VALUE={V(SCL_IN_dynamic1,0)/V(VDD,0)}
ABRIDGE-IN__SCL [A_norm__SCL] [D_norm_del__SCL] adc_norm
Xdel__SCL D_norm_del__SCL D__SCL_OUT DELAY_DIST_LUT

CINA__SDA SDA_IN_dynamic1 VDD 1.5e-12
CINB__SDA SDA_IN_dynamic1 GND 1.5e-12
RINA__SDA SDA_IN_dynamic1 VDD 100000000
RINB__SDA SDA_IN_dynamic1 GND 100000000
DN__SDA GND SDA_IN_dynamic1 clamp_diode_1 ; negative clamp
DP__SDA SDA_IN_dynamic1 VDD clamp_diode_1 ; positive clamp

Enorm__SDA A_norm__SDA GND VALUE={V(SDA_IN_dynamic1,0)/V(VDD,0)}
ABRIDGE-IN__SDA [A_norm__SDA] [D_norm_del__SDA] adc_norm
Xdel__SDA D_norm_del__SDA D__SDA_OUT DELAY_DIST_LUT

* Leakage current at outputs:
R_pin6POSOUTLEAK pin6_OUT_dynamic1 VDD 5e+7
R_pin6NEGOUTLEAK pin6_OUT_dynamic1 GND 5e+7
COUTA__pin6 pin6_OUT_dynamic1 VDD 1.5e-12
COUTB__pin6 pin6_OUT_dynamic1 GND 1.5e-12
ROUTA__pin6 pin6_OUT_dynamic1 VDD 100000000
ROUTB__pin6 pin6_OUT_dynamic1 GND 100000000

R_pin6_OE A_ONE A__pin6_HIZ 1
ABRIDGE-OUT__pin6 [D__lut11_OUT] [A_I__pin6] dac_pin_out
EOUT__pin6 A_OUT_INT__pin6 GND VALUE = {V(A_I__pin6)*V(VDD,GND)}
GOUT__pin6 pin6_OUT_dynamic1 A_OUT_INT__pin6 VALUE = { V(A_STARTUP)*V(A__pin6_HIZ)*(
+ 1*V(A_I__pin6)*V(pin6_OUT_dynamic1,A_OUT_INT__pin6)/V(ROH1X)+
+ 1*(1-V(A_I__pin6))*V(pin6_OUT_dynamic1,A_OUT_INT__pin6)/V(ROL1X)
+ )}

* Leakage current at outputs:
R_pin10POSOUTLEAK pin10_OUT_dynamic1 VDD 5e+7
R_pin10NEGOUTLEAK pin10_OUT_dynamic1 GND 5e+7
COUTA__pin10 pin10_OUT_dynamic1 VDD 1.5e-12
COUTB__pin10 pin10_OUT_dynamic1 GND 1.5e-12
ROUTA__pin10 pin10_OUT_dynamic1 VDD 100000000
ROUTB__pin10 pin10_OUT_dynamic1 GND 100000000

R_pin10_OE A_ONE A__pin10_HIZ 1
ABRIDGE-OUT__pin10 [D__lut13_OUT] [A_I__pin10] dac_pin_out
EOUT__pin10 A_OUT_INT__pin10 GND VALUE = {V(A_I__pin10)*V(VDD,GND)}
GOUT__pin10 pin10_OUT_dynamic1 A_OUT_INT__pin10 VALUE = { V(A_STARTUP)*V(A__pin10_HIZ)*(
+ 1*V(A_I__pin10)*V(pin10_OUT_dynamic1,A_OUT_INT__pin10)/V(ROH1X)+
+ 1*(1-V(A_I__pin10))*V(pin10_OUT_dynamic1,A_OUT_INT__pin10)/V(ROL1X)
+ )}

* Leakage current at outputs:
R_pin11POSOUTLEAK pin11_OUT_dynamic1 VDD 5e+7
R_pin11NEGOUTLEAK pin11_OUT_dynamic1 GND 5e+7
COUTA__pin11 pin11_OUT_dynamic1 VDD 1.5e-12
COUTB__pin11 pin11_OUT_dynamic1 GND 1.5e-12
ROUTA__pin11 pin11_OUT_dynamic1 VDD 100000000
ROUTB__pin11 pin11_OUT_dynamic1 GND 100000000

R_pin11_OE A_ONE A__pin11_HIZ 1
ABRIDGE-OUT__pin11 [D__lut12_OUT] [A_I__pin11] dac_pin_out
EOUT__pin11 A_OUT_INT__pin11 GND VALUE = {V(A_I__pin11)*V(VDD,GND)}
GOUT__pin11 pin11_OUT_dynamic1 A_OUT_INT__pin11 VALUE = { V(A_STARTUP)*V(A__pin11_HIZ)*(
+ 1*V(A_I__pin11)*V(pin11_OUT_dynamic1,A_OUT_INT__pin11)/V(ROH1X)+
+ 1*(1-V(A_I__pin11))*V(pin11_OUT_dynamic1,A_OUT_INT__pin11)/V(ROL1X)
+ )}

*// PIPEDELAY //*

*// POR //*
VSTARTUP A_STARTUP GND PWL(0 0 {1n-1p} 0 1n 1)
ASTARTUP [A_STARTUP] [D_STARTUP] adc_ideal

*// VCC //*
VA_ONE A_ONE GND 1
ABRIDGE_DONE [A_ONE] [D_ONE] adc_ideal

*// VREF //*

*// WAVE //*

*// Models //*
.model adc_ideal adc_bridge(in_low = 0.5 in_high = 0.5 rise_delay=1e-12 fall_delay=1e-12)
.model dac_ideal dac_bridge(out_low=0 out_high=1 out_undef=0 input_load=1e-15 t_rise=1e-12 t_fall=1e-12)
.model dac_pin_out dac_bridge(out_low=0 out_high=1 out_undef=0 input_load=1e-15 t_rise=1e-8 t_fall=1e-8)
.model buf_ideal d_buffer(rise_delay=1e-12 fall_delay=1e-12 input_load=1e-15)
.model and_ideal d_and(rise_delay=1e-12 fall_delay=1e-12 input_load=1e-15)
.model or_ideal d_or(rise_delay=1e-12 fall_delay=1e-12 input_load=1e-15)
.model inv_ideal d_inverter(rise_delay=1e-12 fall_delay=1e-12 input_load=1e-15)
.model buf_del_1ns d_buffer(rise_delay=1e-9 fall_delay=1e-9 input_load=1e-15)
.model and_del_1ns d_and(rise_delay=1e-9 fall_delay=1e-9 input_load=1e-15)
.model or_del_1ns d_or(rise_delay=1e-9 fall_delay=1e-9 input_load=1e-15)
.model inv_del_1ns d_inverter(rise_delay=1e-9 fall_delay=1e-9 input_load=1e-15)
.model xor_ideal d_xor(rise_delay=1e-12 fall_delay=1e-12 input_load=1e-15)
.model hyst_pdly hyst(in_low=0.5 in_high=0.5 hyst={0.19153} out_lower_limit=0 out_upper_limit=1 input_domain=0.01 fraction=TRUE)
.model dff_ideal d_dff(clk_delay=1e-12 set_delay=1e-12 reset_delay=1e-12 ic=0 rise_delay=1e-12 fall_delay=1e-12)
.model adc_norm adc_bridge(in_low = 0.5 in_high = 0.5 rise_delay='1e-9' fall_delay='1e-9')
.model adc_lv_norm adc_bridge(in_low = 0.3 in_high = 0.3 rise_delay='1e-9' fall_delay='1e-9')
.model hyst_norm hyst(in_low=0.5 in_high=0.5 hyst=0.1 out_lower_limit=0 out_upper_limit=1 input_domain=0.01 fraction=TRUE)
.model clamp_diode_1 D (IS=35p RS=64m BV=75 CJO=4p M=0.285 N=1.24)
.ENDS

*// Output and plotting //*

.model dac_ideal dac_bridge(out_low=0 out_high=1 out_undef=0 input_load=1e-15 t_rise=1e-12 t_fall=1e-12)

.control
save
tran 9.999999999999999e-6 1e-2 0e+0
* step units: us
* step value: 0.000009999999999999999
plot  xlimit 0e+0 1e-2
.endc

*// Sub-circuits required for operation //*
* Nanoseconds - 10 segment distributed delay (up to one full period of delay)
* 7
.SUBCKT DELAY_DIST_LUT IN OUT
.model dist_dly_buff d_buffer(rise_delay = 3.5n fall_delay = 3.5n)
A_out_buff IN OUT dist_dly_buff
.ENDS DELAY_DIST_LUT

.SUBCKT LOGIC_TRI_STATE_OUTPUT IN OUT OEZ VCC VEE
EROH NROH VEE TABLE {V(VCC,VEE)} =
+ (1.8,61)
+ (3.3,50)
+ (5,37)
EROL NROL VEE TABLE {V(VCC,VEE)} =
+ (1.8,18)
+ (3.3,14)
+ (5,9)
EOEZ N2 VEE VALUE = {V(OEZ,VEE)}
E1 N1 VEE VALUE = {V(VCC,VEE)*V(IN,VEE)*V(N2,VEE)}
GOUT N1 OUT VALUE = {V(N1,OUT)*V(N2,VEE)*(V(IN,VEE)/V(NROH,VEE) + (1 - V(IN,VEE))/V(NROL,VEE))}
ROUT OUT VEE 1E8
.ENDS

.SUBCKT SUPPLY_CURRENT VCC VEE
+ PARAMS:
+  ICC = 100n
+  VMAX = 5.5
+  VMIN = 1.65
.PARAM RCC = VMAX/ICC
GICC VCC VEE VALUE = {IF(V(VCC,VEE)<VMIN,1,0)*V(VCC,VEE)/RCC}
.ENDS

.end
