RECTIFIER (TINA Netlist Editor format)
**************************************
**  This file was created by TINA   **
**         www.tina.com             **
**      (c) DesignSoft, Inc.        **
**     www.designsoftware.com       **
**************************************
.LIB "<TINADIR>\EXAMPLES\SPICE\TSPICE.LIB"
.LIB "<TINADIR>\SPICELIB\Operational Amplifiers.LIB"
.TEMP 27
.AC DEC 20 10 1MEG
.TRAN 2N 1U
.DC LIN VSWGPIO1 0 1 10M

.PROBE V(1,2) V([VF1])

VSWGPIO1    3 0 DC 0 AC 1 0
+ PULSE ( 0 1 0  0  0  1e19 1e20 )
VS1         1 2 5
SW2         VF1 5 3 0  S_VSWITCH_1
R1          5 VF1 10
D4          2 5  D_1N1183_1
D3          0 2  D_1N1183_1
D2          1 5  D_1N1183_1
R2          VF1 0 10
D1          0 1  D_1N1183_1
C1          VF1 0 470U

.MODEL D_1N1183_1 D( IS=36N N=1.6 BV=50 RZ=10 IBV=5M
+      RS=2M CJO=460P VJ=550M M=440M FC=500M
+      TT=434.7N EG=1.11 XTI=3 KF=0 AF=1
+      )
.MODEL S_VSWITCH_1 VSWITCH (RON=0 ROFF=1G VON=1 VOFF=0)

.END
