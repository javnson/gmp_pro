buck (TINA Netlist Editor format)
**************************************
**  This file was created by TINA   **
**         www.tina.com             **
**      (c) DesignSoft, Inc.        **
**     www.designsoftware.com       **
**************************************
.LIB "<TINADIR>\EXAMPLES\SPICE\TSPICE.LIB"
.LIB "<TINADIR>\SPICELIB\Operational Amplifiers.LIB"
.TEMP 27
.AC DEC 20 10 1MEG
.TRAN 2N 1U
.DC LIN VPWM1 0 1 10M

.PROBE I(VAM1) V([VF1])

VAM1        1 2 ; Current Arrow
VPWM1       3 1 DC 0 AC 1 0
+ PULSE ( 0 1 0  0  0  1e19 1e20 )
VS1         5 0 5
R2          VF1 0 10
D1          0 1  D_1N1183_1
MT1         5 3 1 1  ME_2N6755_N_1 NRD=0 NRS=0
C1          VF1 0 10U
R1          6 VF1 50M
L1          2 6 1M IC=0

.MODEL D_1N1183_1 D( IS=36N N=1.6 BV=50 RZ=10 IBV=5M
+      RS=2M CJO=460P VJ=550M M=440M FC=500M
+      TT=434.7N EG=1.11 XTI=3 KF=0 AF=1
+      )
.MODEL ME_2N6755_N_1 NMOS( LEVEL=3 VTO=3.128 KP=21.14U PHI=600M GAMMA=0 TOX=100N
+      UO=600 VMAX=0 DELTA=0 THETA=0 ETA=0
+      L=2U W=1.1 RD=64.68M RS=120.7M RG=5.839
+      RB=0 RDS=600K IS=44.14F N=1 PB=800M
+      CBD=1.261N CBS=0 MJ=500M TT=370N CGSO=725.6P
+      CGDO=310.6P CGBO=0 KF=0 AF=1 )

.END
